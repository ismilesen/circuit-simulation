* Test fixture: upload this first to trigger the missing subcircuit prompt.
* It calls gain_block, but does not define or include gain_block.

V1 in 0 DC 1
XU1 in out gain_block
RLOAD out 0 10k

.tran 1u 1m
.end
