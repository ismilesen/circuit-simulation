* Sky130 primitive NAND2 demo.
* VA and VB are driven by the app through external voltage-source callbacks.

.lib "$PDK_ROOT/libs.tech/ngspice/sky130.lib.spice" tt

VDD VPWR 0 1.8
VA A 0 external
VB B 0 external
XMPA OUT A VPWR VPWR sky130_fd_pr__pfet_01v8 L=0.15 W=2 nf=1 ad=0.58 as=0.58 pd=4.58 ps=4.58 nrd=0.145 nrs=0.145 sa=0 sb=0 sd=0 mult=1 m=1
XMPB OUT B VPWR VPWR sky130_fd_pr__pfet_01v8 L=0.15 W=2 nf=1 ad=0.58 as=0.58 pd=4.58 ps=4.58 nrd=0.145 nrs=0.145 sa=0 sb=0 sd=0 mult=1 m=1
XMNA OUT A NINT 0 sky130_fd_pr__nfet_01v8 L=0.15 W=1 nf=1 ad=0.29 as=0.29 pd=2.58 ps=2.58 nrd=0.29 nrs=0.29 sa=0 sb=0 sd=0 mult=1 m=1
XMNB NINT B 0 0 sky130_fd_pr__nfet_01v8 L=0.15 W=1 nf=1 ad=0.29 as=0.29 pd=2.58 ps=2.58 nrd=0.29 nrs=0.29 sa=0 sb=0 sd=0 mult=1 m=1
CLOAD OUT 0 5f

.tran 10p 10n
.end
